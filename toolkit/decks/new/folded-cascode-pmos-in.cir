* hand-written deck, not exported from any drawing
* folded cascode with a PMOS input pair (the AIC midterm, upside down)
.title Folded cascode, PMOS input
.global VDD
.subckt FCP vb1 vb2 vb3 vb4 vb5 inp inn outl outr
.iodir vb1=input vb2=input vb3=input vb4=input vb5=input inp=input inn=input outl=output outr=output
.name inp V_inp
.name inn V_inn
.name outl V_out1
.name outr V_out2
.name vb1 V_b1
.name vb2 V_b2
.name vb3 V_b3
.name vb4 V_b4
.name vb5 V_b5
M11 tail vb5 VDD VDD pmos
M1 fl inp tail VDD pmos
M2 fr inn tail VDD pmos
M7 xl vb4 VDD VDD pmos
M8 xr vb4 VDD VDD pmos
M5 outl vb3 xl VDD pmos
M6 outr vb3 xr VDD pmos
M3 outl vb2 fl 0 nmos
M4 outr vb2 fr 0 nmos
M9 fl vb1 0 0 nmos
M10 fr vb1 0 0 nmos
.ends
