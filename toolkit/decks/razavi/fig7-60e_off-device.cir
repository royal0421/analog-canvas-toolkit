* hand-written from Razavi Fig. 7.60(e) -- topology only, no geometry
.title Razavi Fig. 7.60(e) — pmos input with a grounded-gate device on the output
.global VDD
.subckt Fig7_60e vin vb vout
.iodir vin=input vb=input vout=output
.name vin V_in
.name vb V_b
.name vout V_out
M2 vout vin VDD VDD pmos
.name M2 M_2
M1 vout vb 0 0 nmos
.name M1 M_1
M3 vout 0 0 0 nmos
.name M3 M_3
.ends
