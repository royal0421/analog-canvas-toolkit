* hand-written deck (textbook topology), not exported from any drawing
.title Common-source stage with PMOS diode-connected load
.global VDD
.subckt CsDiode in out
.iodir in=input out=output
.name in V_in
.name out V_out
M2 out out VDD VDD pmos
.name M2 M_2
M1 out in 0 0 nmos
.name M1 M_1
.ends
