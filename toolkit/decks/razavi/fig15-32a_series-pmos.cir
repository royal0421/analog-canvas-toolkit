* hand-written from Razavi Fig. 15.32(a) -- topology only, no geometry
.title Razavi Fig. 15.32(a) — two pmos devices in series
.global VDD
.subckt Fig15_32a a b vout
.iodir a=input b=input vout=output
.name a A
.name b B
.name vout V_out
M4 n1 a VDD VDD pmos
.name M4 M_4
M3 vout b n1 VDD pmos
.name M3 M_3
.ends
